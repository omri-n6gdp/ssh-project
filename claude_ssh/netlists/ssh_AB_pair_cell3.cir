* SSH AB pair cell 3, delta=gamma=0.3
V1 N001 0 AC 1.0
Cb N001 0 3.300000e-09 Rser=1.0
L1 0 N001 2.200000e-03 Rser=1.0
L2 0 N002 2.200000e-03 Rser=1.0
L3 0 N003 2.200000e-03 Rser=1.0
L4 0 N004 2.200000e-03 Rser=1.0
L5 0 N005 2.200000e-03 Rser=1.0
L6 0 N006 2.200000e-03 Rser=1.0
L7 0 N007 2.200000e-03 Rser=1.0
L8 0 N008 2.200000e-03 Rser=1.0
L9 0 N009 2.200000e-03 Rser=1.0
L10 0 N010 2.200000e-03 Rser=1.0
L11 0 N011 2.200000e-03 Rser=1.0
L12 0 N012 2.200000e-03 Rser=1.0
L13 0 N013 2.200000e-03 Rser=1.0
L14 0 N014 2.200000e-03 Rser=1.0
L15 0 N015 2.200000e-03 Rser=1.0
L16 0 N016 2.200000e-03 Rser=1.0
C1 N001 N002 2.200000e-09 Rser=1.0  ; C1 cell 1
C2 N003 N004 2.200000e-09 Rser=1.0  ; C1 cell 2
C3 N005 N006 2.860000e-09 Rser=1.0  ; C1 cell 3
C4 N007 N008 2.200000e-09 Rser=1.0  ; C1 cell 4
C5 N009 N010 2.200000e-09 Rser=1.0  ; C1 cell 5
C6 N011 N012 2.200000e-09 Rser=1.0  ; C1 cell 6
C7 N013 N014 2.200000e-09 Rser=1.0  ; C1 cell 7
C8 N015 N016 2.200000e-09 Rser=1.0  ; C1 cell 8
C9 N002 N003 3.300000e-09 Rser=1.0  ; C2 cell 1
C10 N004 N005 4.290000e-09 Rser=1.0  ; C2 cell 2
C11 N006 N007 4.290000e-09 Rser=1.0  ; C2 cell 3
C12 N008 N009 3.300000e-09 Rser=1.0  ; C2 cell 4
C13 N010 N011 3.300000e-09 Rser=1.0  ; C2 cell 5
C14 N012 N013 3.300000e-09 Rser=1.0  ; C2 cell 6
C15 N014 N015 3.300000e-09 Rser=1.0  ; C2 cell 7
.ac dec 400 20k 120k
.end
